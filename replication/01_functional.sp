* PTM65 Figure 4: functional baseline and timing
.include "common.inc"
.include "functional_inputs.inc"
.include "functional_measure.inc"
.tran 1p 80n
.end
