* Common-mode sweep at selected sizing
.include "common.inc"
.include "functional_inputs.inc"
.include "functional_measure.inc"
.tran 2p 80n SWEEP VCM 0.45 0.85 0.10
.end
