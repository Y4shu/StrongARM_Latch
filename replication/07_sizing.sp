* Ten LUT-informed candidates; dimensions are hypotheses, not optimized results
.include "common.inc"
.include "functional_inputs.inc"
.include "functional_measure.inc"
.include "size_grid.inc"
.tran 2p 80n SWEEP DATA=SIZE_GRID
.end
